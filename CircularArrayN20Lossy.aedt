# Ansys Electronics Desktop project, version 2018.1
materials:
  PMLGroup2_XYZ_1: permittivity{anisotropic component1=1.1 component2=1.1 component3=1.1} permeability{anisotropic component1=1.1 component2=1.1 component3=1.1} dielectric_loss_tangent{anisotropic component1=1 component2=1 component3=1} magnetic_loss_tangent{anisotropic component1=1 component2=1 component3=1}
  PMLGroup2_XZ_1: permittivity{anisotropic component1=1 component2=0.01 component3=1} permeability{anisotropic component1=1 component2=0.01 component3=1} dielectric_loss_tangent{anisotropic component1=0 component2=242 component3=0} magnetic_loss_tangent{anisotropic component1=0 component2=242 component3=0}
  PMLGroup2_YZ_1: permittivity{anisotropic component1=0.01 component2=1 component3=1} permeability{anisotropic component1=0.01 component2=1 component3=1} dielectric_loss_tangent{anisotropic component1=242 component2=0 component3=0} magnetic_loss_tangent{anisotropic component1=242 component2=0 component3=0}
  PMLGroup2_Z_1: permittivity{anisotropic component1=1.1 component2=1.1 component3=0.45454545} permeability{anisotropic component1=1.1 component2=1.1 component3=0.45454545} dielectric_loss_tangent{anisotropic component1=1 component2=1 component3=-1} magnetic_loss_tangent{anisotropic component1=1 component2=1 component3=-1}
  pec: conductivity=1e+30
  vacuum: permittivity=1
  PMLGroup2_Z_2: permittivity{anisotropic component1=1.1 component2=1.1 component3=0.45454545} permeability{anisotropic component1=1.1 component2=1.1 component3=0.45454545} dielectric_loss_tangent{anisotropic component1=1 component2=1 component3=-1} magnetic_loss_tangent{anisotropic component1=1 component2=1 component3=-1}
  PMLGroup2_XZ_2: permittivity{anisotropic component1=1 component2=0.01 component3=1} permeability{anisotropic component1=1 component2=0.01 component3=1} dielectric_loss_tangent{anisotropic component1=0 component2=242 component3=0} magnetic_loss_tangent{anisotropic component1=0 component2=242 component3=0}
  PMLGroup2_YZ_2: permittivity{anisotropic component1=0.01 component2=1 component3=1} permeability{anisotropic component1=0.01 component2=1 component3=1} dielectric_loss_tangent{anisotropic component1=242 component2=0 component3=0} magnetic_loss_tangent{anisotropic component1=242 component2=0 component3=0}
  PMLGroup2_XYZ_2: permittivity{anisotropic component1=1.1 component2=1.1 component3=1.1} permeability{anisotropic component1=1.1 component2=1.1 component3=1.1} dielectric_loss_tangent{anisotropic component1=1 component2=1 component3=1} magnetic_loss_tangent{anisotropic component1=1 component2=1 component3=1}

design HFSSDesign1 (HFSS, DrivenModal, model units mm)
variables:
  h = (43.6/2) mm
  gap = 2*h/100
  a = 3.17mm
  d = 35.46mm
  N = 20
  RR = d/(2*sin(pi/N))
geometry:
  SourceDipole1a [vacuum] = cylinder(axis=Z, base_centre=(RR, 0mm, gap/2), radius=a, height=h-gap/2)
  SourceDipole1b [vacuum] = cylinder(axis=Z, base_centre=(RR, 0mm, -gap/2), radius=a, height=-(h-gap/2))
  Rectangle1 = rectangle(corner=(RR, -a, -gap/2), y_size=2*a, z_size=gap)
  RadiatingSurface [vacuum] = region(absolute_offset=29.411765mm on all sides)
  coordinate_system FaceCS1 = face of RadiatingSurface: Origin=RadiatingSurface.vertex(1 of 8) FaceID=RadiatingSurface.face(+z) AxisPosn=RadiatingSurface.vertex(2 of 8) WhichAxis=X
  PML_RadiatingSurface_1 [PMLGroup2_Z_2, oriented by FaceCS1] = sweep_along_normal(RadiatingSurface.face(+z), length=105.52896mm)
  coordinate_system FaceCS2 = face of RadiatingSurface: Origin=RadiatingSurface.vertex(5 of 8) FaceID=RadiatingSurface.face(-z) AxisPosn=RadiatingSurface.vertex(6 of 8) WhichAxis=X
  PML_RadiatingSurface_2 [PMLGroup2_Z_2, oriented by FaceCS2] = sweep_along_normal(RadiatingSurface.face(-z), length=105.52896mm)
  coordinate_system FaceCS3 = face of RadiatingSurface: Origin=RadiatingSurface.vertex(4 of 8) FaceID=RadiatingSurface.face(-y) AxisPosn=RadiatingSurface.vertex(7 of 8) WhichAxis=X
  PML_RadiatingSurface_3 [PMLGroup2_Z_2, oriented by FaceCS3] = sweep_along_normal(RadiatingSurface.face(-y), length=105.52896mm)
  coordinate_system FaceCS4 = face of RadiatingSurface: Origin=RadiatingSurface.vertex(3 of 8) FaceID=RadiatingSurface.face(-x) AxisPosn=RadiatingSurface.vertex(8 of 8) WhichAxis=X
  PML_RadiatingSurface_4 [PMLGroup2_Z_2, oriented by FaceCS4] = sweep_along_normal(RadiatingSurface.face(-x), length=105.52896mm)
  coordinate_system FaceCS5 = face of RadiatingSurface: Origin=RadiatingSurface.vertex(2 of 8) FaceID=RadiatingSurface.face(+y) AxisPosn=RadiatingSurface.vertex(5 of 8) WhichAxis=X
  PML_RadiatingSurface_5 [PMLGroup2_Z_2, oriented by FaceCS5] = sweep_along_normal(RadiatingSurface.face(+y), length=105.52896mm)
  coordinate_system FaceCS6 = face of RadiatingSurface: Origin=RadiatingSurface.vertex(1 of 8) FaceID=RadiatingSurface.face(+x) AxisPosn=RadiatingSurface.vertex(6 of 8) WhichAxis=X
  PML_RadiatingSurface_6 [PMLGroup2_Z_2, oriented by FaceCS6] = sweep_along_normal(RadiatingSurface.face(+x), length=105.52896mm)
  PML_RadiatingSurface_7 [PMLGroup2_XZ_2, oriented by FaceCS3] = sweep_along_normal(PML_RadiatingSurface_1.face(at (0, -145.92, 103.976)), length=105.52896mm)
  PML_RadiatingSurface_8 [PMLGroup2_XZ_2, oriented by FaceCS4] = sweep_along_normal(PML_RadiatingSurface_1.face(at (-145.92, 0, 103.976)), length=105.52896mm)
  PML_RadiatingSurface_9 [PMLGroup2_XZ_2, oriented by FaceCS5] = sweep_along_normal(PML_RadiatingSurface_1.face(at (0, 145.92, 103.976)), length=105.52896mm)
  PML_RadiatingSurface_10 [PMLGroup2_YZ_2, oriented by FaceCS1] = sweep_along_normal(PML_RadiatingSurface_1.face(at (145.92, 0, 103.976)), length=105.52896mm)
  coordinate_system FaceCS7 = face of RadiatingSurface: Origin=RadiatingSurface.vertex(6 of 8) FaceID=RadiatingSurface.face(-z) AxisPosn=RadiatingSurface.vertex(7 of 8) WhichAxis=X
  PML_RadiatingSurface_11 [PMLGroup2_YZ_2, oriented by FaceCS7] = sweep_along_normal(PML_RadiatingSurface_2.face(at (0, -145.92, -103.976)), length=105.52896mm)
  coordinate_system FaceCS8 = face of RadiatingSurface: Origin=RadiatingSurface.vertex(7 of 8) FaceID=RadiatingSurface.face(-z) AxisPosn=RadiatingSurface.vertex(8 of 8) WhichAxis=X
  PML_RadiatingSurface_12 [PMLGroup2_YZ_2, oriented by FaceCS8] = sweep_along_normal(PML_RadiatingSurface_2.face(at (-145.92, 0, -103.976)), length=105.52896mm)
  PML_RadiatingSurface_13 [PMLGroup2_XZ_2, oriented by FaceCS2] = sweep_along_normal(PML_RadiatingSurface_2.face(at (0, 145.92, -103.976)), length=105.52896mm)
  PML_RadiatingSurface_14 [PMLGroup2_YZ_2, oriented by FaceCS2] = sweep_along_normal(PML_RadiatingSurface_2.face(at (145.92, 0, -103.976)), length=105.52896mm)
  PML_RadiatingSurface_15 [PMLGroup2_YZ_2, oriented by FaceCS3] = sweep_along_normal(PML_RadiatingSurface_3.face(at (-145.92, -198.684, 0)), length=105.52896mm)
  PML_RadiatingSurface_16 [PMLGroup2_YZ_2, oriented by FaceCS6] = sweep_along_normal(PML_RadiatingSurface_3.face(at (145.92, -198.684, 0)), length=105.52896mm)
  PML_RadiatingSurface_17 [PMLGroup2_YZ_2, oriented by FaceCS4] = sweep_along_normal(PML_RadiatingSurface_4.face(at (-198.684, 145.92, 0)), length=105.52896mm)
  PML_RadiatingSurface_18 [PMLGroup2_YZ_2, oriented by FaceCS5] = sweep_along_normal(PML_RadiatingSurface_5.face(at (145.92, 198.684, 0)), length=105.52896mm)
  PML_RadiatingSurface_19 [PMLGroup2_XYZ_2, oriented by FaceCS3] = sweep_along_normal(PML_RadiatingSurface_7.face(at (-145.92, -198.684, 103.976)), length=105.52896mm)
  PML_RadiatingSurface_20 [PMLGroup2_XYZ_2, oriented by FaceCS1] = sweep_along_normal(PML_RadiatingSurface_7.face(at (145.92, -198.684, 103.976)), length=105.52896mm)
  PML_RadiatingSurface_21 [PMLGroup2_XYZ_2, oriented by FaceCS4] = sweep_along_normal(PML_RadiatingSurface_8.face(at (-198.684, 145.92, 103.976)), length=105.52896mm)
  PML_RadiatingSurface_22 [PMLGroup2_XYZ_2, oriented by FaceCS5] = sweep_along_normal(PML_RadiatingSurface_9.face(at (145.92, 198.684, 103.976)), length=105.52896mm)
  PML_RadiatingSurface_23 [PMLGroup2_XYZ_2, oriented by FaceCS8] = sweep_along_normal(PML_RadiatingSurface_11.face(at (-145.92, -198.684, -103.976)), length=105.52896mm)
  PML_RadiatingSurface_24 [PMLGroup2_XYZ_2, oriented by FaceCS7] = sweep_along_normal(PML_RadiatingSurface_11.face(at (145.92, -198.684, -103.976)), length=105.52896mm)
  coordinate_system FaceCS9 = face of RadiatingSurface: Origin=RadiatingSurface.vertex(8 of 8) FaceID=RadiatingSurface.face(-z) AxisPosn=RadiatingSurface.vertex(5 of 8) WhichAxis=X
  PML_RadiatingSurface_25 [PMLGroup2_XYZ_2, oriented by FaceCS9] = sweep_along_normal(PML_RadiatingSurface_12.face(at (-198.684, 145.92, -103.976)), length=105.52896mm)
  PML_RadiatingSurface_26 [PMLGroup2_XYZ_2, oriented by FaceCS2] = sweep_along_normal(PML_RadiatingSurface_13.face(at (145.92, 198.684, -103.976)), length=105.52896mm)
  Dipole2 [vacuum] = cylinder(axis=Z, base_centre=(RR*cos(1*2*pi/N), RR*sin(1*2*pi/N), -h), radius=a, height=2*h)
  Dipole3 [vacuum] = cylinder(axis=Z, base_centre=(RR*cos(2*2*pi/N), RR*sin(2*2*pi/N), -h), radius=a, height=2*h)
  Dipole4 [vacuum] = cylinder(axis=Z, base_centre=(RR*cos(3*2*pi/N), RR*sin(3*2*pi/N), -h), radius=a, height=2*h)
  Dipole5 [vacuum] = cylinder(axis=Z, base_centre=(RR*cos(4*2*pi/N), RR*sin(4*2*pi/N), -h), radius=a, height=2*h)
  Dipole6 [vacuum] = cylinder(axis=Z, base_centre=(RR*cos(5*2*pi/N), RR*sin(5*2*pi/N), -h), radius=a, height=2*h)
  Dipole7 [vacuum] = cylinder(axis=Z, base_centre=(RR*cos(6*2*pi/N), RR*sin(6*2*pi/N), -h), radius=a, height=2*h)
  Dipole8 [vacuum] = cylinder(axis=Z, base_centre=(RR*cos(7*2*pi/N), RR*sin(7*2*pi/N), -h), radius=a, height=2*h)
  Dipole9 [vacuum] = cylinder(axis=Z, base_centre=(RR*cos(8*2*pi/N), RR*sin(8*2*pi/N), -h), radius=a, height=2*h)
  Dipole10 [vacuum] = cylinder(axis=Z, base_centre=(RR*cos(9*2*pi/N), RR*sin(9*2*pi/N), -h), radius=a, height=2*h)
  Dipole11 [vacuum] = cylinder(axis=Z, base_centre=(RR*cos(10*2*pi/N), RR*sin(10*2*pi/N), -h), radius=a, height=2*h)
  Dipole12 [vacuum] = cylinder(axis=Z, base_centre=(RR*cos(11*2*pi/N), RR*sin(11*2*pi/N), -h), radius=a, height=2*h)
  Dipole13 [vacuum] = cylinder(axis=Z, base_centre=(RR*cos(12*2*pi/N), RR*sin(12*2*pi/N), -h), radius=a, height=2*h)
  Dipole14 [vacuum] = cylinder(axis=Z, base_centre=(RR*cos(13*2*pi/N), RR*sin(13*2*pi/N), -h), radius=a, height=2*h)
  Dipole15 [vacuum] = cylinder(axis=Z, base_centre=(RR*cos(14*2*pi/N), RR*sin(14*2*pi/N), -h), radius=a, height=2*h)
  Dipole16 [vacuum] = cylinder(axis=Z, base_centre=(RR*cos(15*2*pi/N), RR*sin(15*2*pi/N), -h), radius=a, height=2*h)
  Dipole17 [vacuum] = cylinder(axis=Z, base_centre=(RR*cos(16*2*pi/N), RR*sin(16*2*pi/N), -h), radius=a, height=2*h)
  Dipole18 [vacuum] = cylinder(axis=Z, base_centre=(RR*cos(17*2*pi/N), RR*sin(17*2*pi/N), -h), radius=a, height=2*h)
  Dipole19 [vacuum] = cylinder(axis=Z, base_centre=(RR*cos(18*2*pi/N), RR*sin(18*2*pi/N), -h), radius=a, height=2*h)
  Dipole20 [vacuum] = cylinder(axis=Z, base_centre=(RR*cos(19*2*pi/N), RR*sin(19*2*pi/N), -h), radius=a, height=2*h)
boundaries and excitations:
  PML_radiation1: Radiation Faces=RadiatingSurface.face(+z) IsForPML
  PML_radiation2: Radiation Faces=RadiatingSurface.face(-z) IsForPML
  PML_radiation3: Radiation Faces=RadiatingSurface.face(-y) IsForPML
  PML_radiation4: Radiation Faces=RadiatingSurface.face(-x) IsForPML
  PML_radiation5: Radiation Faces=RadiatingSurface.face(+y) IsForPML
  PML_radiation6: Radiation Faces=RadiatingSurface.face(+x) IsForPML
  FiniteCond1: Finite Conductivity Faces=SourceDipole1a.face(1 of 3) SourceDipole1b.face(1 of 3) Dipole2.face(1 of 3) Dipole3.face(1 of 3) Dipole4.face(1 of 3) Dipole5.face(1 of 3) Dipole6.face(1 of 3) Dipole7.face(1 of 3) Dipole8.face(1 of 3) Dipole9.face(1 of 3) Dipole10.face(1 of 3) Dipole11.face(1 of 3) Dipole12.face(1 of 3) Dipole13.face(1 of 3) Dipole14.face(1 of 3) Dipole15.face(1 of 3) Dipole16.face(1 of 3) Dipole17.face(1 of 3) Dipole18.face(1 of 3) Dipole19.face(1 of 3) Dipole20.face(1 of 3) Conductivity=14000000 Permeability=1 IsInternal
  FiniteCond2: Finite Conductivity Faces=SourceDipole1b.face(3 of 3) SourceDipole1a.face(2 of 3) Conductivity=14000000 Permeability=1 IsInternal
  1: Lumped Port Objects=Rectangle1 Modes{Mode1{IntLine{middle of Rectangle1.edge(z at corner) -> middle of Rectangle1.edge(z opposite corner)} CharImp=Zpi}} Impedance=73ohm
setups:
  Setup1: HfssDriven AdaptMultipleFreqs MultipleAdaptiveFreqsSetup{Broadband{Low=2.5GHz High=2.8GHz}} MaxDeltaS=0.02 MaximumPasses=18 MinimumPasses=1 MinimumConvergedPasses=1 PercentRefinement=30 BasisOrder=1 PortAccuracy=2
    sweep Sweep: 2.5GHz to 2.8GHz step 50kHz; Type=Fast SaveFields
source amplitudes:
  1:1: 1W 0deg
radiation setups:
  3D: Infinite Sphere Theta=0deg..180deg step 2deg Phi=-180deg..180deg step 2deg
  Elevation: Infinite Sphere Theta=-180deg..180deg step 1deg Phi=0deg..90deg step 90deg
  Azimuth: Infinite Sphere Theta=90deg..90deg step 0deg Phi=-180deg..180deg step 1deg
reports:
  Y Parameter Plot 1: re(Y(1,1)), im(Y(1,1)) vs Freq on Setup1 : Sweep; markers m1 at 2.67555GHz
